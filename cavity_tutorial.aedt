# Ansys Electronics Desktop project, version 2016.2
materials:
  vacuum: permittivity=1

design HFSSDesign1 (HFSS, Eigenmode, model units cm)
variables:
  cavity_rad = 21cm
  cavity_height = 100cm
geometry:
  cavity [vacuum] = cylinder(axis=Z, base_centre=(0cm, 0cm, 0cm), radius=cavity_rad, height=cavity_height)
boundaries and excitations:
  cavity_walls: Finite Conductivity Faces=cavity.face(all 3) Conductivity=58000000 Permeability=1 IsInternal
mesh:
  cavity: Curvilinear Objects=cavity Apply
  initial mesh: GlobalCurvilinear{Apply}
setups:
  Setup1: HfssEigen MinimumFrequency=540MHz NumModes=3 MaxDeltaFreq=2 ConvergeOnRealFreq=false MaximumPasses=12 MinimumPasses=4 MinimumConvergedPasses=1 PercentRefinement=30 BasisOrder=1
source amplitudes:
  #-10:1: 1 0deg
  #-10:2, #-10:3: 0 0deg
field plots:
  Mag_E1, Vector_E1: E Field on Setup1 : LastAdaptive at Phase=0deg
